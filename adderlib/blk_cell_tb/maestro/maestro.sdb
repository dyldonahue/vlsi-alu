ADE simulation setup
Run mode: Single Run, Sweeps and Corners
Tests:
  adderlib:blk_cell_tb:1: adderlib/blk_cell_tb/schematic, simulator spectre
    Variables: w = 120n
