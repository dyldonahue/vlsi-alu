ADE simulation setup
Test adderlib:gp_cell_tb:1: adderlib/gp_cell_tb/schematic, simulator spectre
  Models: /ECEnet/Apps1/linux/cad12/tools/PDKs/gpdk045_v_3_5/gpdk045/../models/spectre/gpdk045.scs[mc]
  Variables: w = 120n
  Temperature: 27
  Analysis tran: stop=20n errpreset=moderate
  Signals: /a, /gout, /pout
