ADE simulation setup
Run mode: Single Run, Sweeps and Corners
Tests:
  Standard_Cells:buffer_tb:1: Standard_Cells/buffer_tb/schematic, simulator spectre
    Variables: w = 150n
