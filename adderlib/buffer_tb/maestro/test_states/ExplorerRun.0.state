ADE simulation setup
Test Standard_Cells:buffer_tb:1: Standard_Cells/buffer_tb/schematic, simulator spectre
  Models: /ECEnet/Apps1/linux/cad12/tools/PDKs/gpdk045_v_3_5/gpdk045/../models/spectre/gpdk045.scs[mc]
  Variables: w = 150n
  Temperature: 27
  Analysis tran: stop=20n errpreset=moderate
  Signals: /in, /out
