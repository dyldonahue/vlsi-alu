ADE simulation setup
Test logic_unit:logic_cell_tb:1: logic_unit/logic_cell_tb/schematic, simulator spectre
  Models: /ECEnet/Apps1/linux/cad12/tools/PDKs/gpdk045_v_3_5/gpdk045/../models/spectre/gpdk045.scs[mc]
  Variables: a = 0; b = 0; s0 = 1.2; s1 = 1.2
  Temperature: 27
  Analysis tran: stop=20n
  Output fallTime(VS("/out") 1.2 nil 0 nil 10 90 nil "time")
  Output delay(VT("/A") VT("/out") 0.6 0.6)
  Signals: /a, /b, /s1, /s0, /out
Run mode: Single Run, Sweeps and Corners
