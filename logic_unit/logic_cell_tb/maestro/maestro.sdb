ADE simulation setup
Run mode: Single Run, Sweeps and Corners
Tests:
  logic_unit:logic_cell_tb:1: logic_unit/logic_cell_tb/schematic, simulator spectre
    Variables: a = 0; b = 0; s0 = 1.2; s1 = 1.2
    Outputs: fallTime(VS("/out") 1.2 nil 0 nil 10 90 nil "time"); delay(VT("/A") VT("/out") 0.6 0.6)
