ADE simulation setup
Run mode: Single Run, Sweeps and Corners
Tests:
  adderlib:gp_cell_tb:1: adderlib/gp_cell_tb/schematic, simulator spectre
    Variables: w = 120n
