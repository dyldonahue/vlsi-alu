ADE simulation setup
Test adderlib:gry_cell_tb:1: adderlib/gry_cell_tb/schematic, simulator spectre
  Models: /ECEnet/Apps1/linux/cad12/tools/PDKs/gpdk045_v_3_5/gpdk045/../models/spectre/gpdk045.scs[mc]
  Variables: w = 120n
  Temperature: 27
  Analysis tran: stop=20n errpreset=moderate
  Signals: /g_hi, /gout
Run mode: Single Run, Sweeps and Corners
